ADE simulation setup
Run mode: Single Run, Sweeps and Corners
Tests:
  LowPower_28_Rail2Railcomparator_SR_speed_TB_1: LowPower_28/Rail2Railcomparator_SR_speed_TB/schematic, simulator spectre
    Variables: tr = 10p; VDD = 1; vin = 1000u; fclk = 1G; Vcommon = {From/To}LinearStepCount:0:100:1{From/To}; tdelay_data = 0.5/fclk; TSTOP = 20/fclk
