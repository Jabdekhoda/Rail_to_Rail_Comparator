ADE simulation setup
Test LowPower_28_Rail2Railcomparator_SR_speed_TB_1: LowPower_28/Rail2Railcomparator_SR_speed_TB/schematic, simulator spectre
  Models: /afs/ee.ust.hk/amd64_linux26/usr/eelocal/tsmchome_eeweiz/Cadence/ViewCadence_RF/tsmcN28/../models/spectre/toplevel.scs[TOP_TT]
  Variables: tr = 10p; VDD = 1; vin = 1000u; fclk = 1G; Vcommon = VDD/2; tdelay_data = 0.5/fclk; TSTOP = 20/fclk
  Temperature: 27
  Analysis tran: stop=VAR("TSTOP") errpreset=conservative
  Output v /OUT_N; tran (V) = vtime('tran "/OUT_N") (unticked)
  Output v /OUTB_N; tran (V) = vtime('tran "/OUTB_N") (unticked)
  Output v /OUT_R; tran (V) = vtime('tran "/OUT_R") (unticked)
  Output v /OUTB_R; tran (V) = vtime('tran "/OUTB_R") (unticked)
  Output OUT_N = (vtime('tran "/OUT_N") - vtime('tran "/OUTB_N")) (unticked)
  Output OUT_P = (vtime('tran "/OUT_P") - vtime('tran "/OUTB_P")) (unticked)
  Output OUT_R = (vtime('tran "/OUT_R") - vtime('tran "/OUTB_R")) (unticked)
  Output CK = clip(((2 * vtime('tran "/CK")) - VAR("VDD")) (3 / VAR("fclk")) VAR("TSTOP")) (unticked)
  Output NMOS_Diff = clip(OUT_N (3 / VAR("fclk")) VAR("TSTOP")) (unticked)
  Output PMOS_Diff = clip(OUT_P (3 / VAR("fclk")) VAR("TSTOP")) (unticked)
  Output R2R_Diff = clip(OUT_R (3 / VAR("fclk")) VAR("TSTOP")) (unticked)
  Output delay_P = min((cross(PMOS_Diff (VAR("VDD") / 1.1) 1 "rising" nil nil nil) - cross(CK (VAR("VDD") / 1.1) 1 "rising" nil nil nil)) 1e-09)
  Output delay_N = min((cross(NMOS_Diff (VAR("VDD") / 1.1) 1 "rising" nil nil nil) - cross(CK (VAR("VDD") / 1.1) 1 "rising" nil nil nil)) 1e-09)
  Output delay_R = min((cross(R2R_Diff (VAR("VDD") / 1.1) 1 "rising" nil nil nil) - cross(CK (VAR("VDD") / 1.1) 1 "rising" nil nil nil)) 1e-09)
  Output I_N = average(itime('tran "/VDDN/PLUS")) (unticked)
  Output I_P = average(itime('tran "/VDDP/PLUS")) (unticked)
  Output I_R = average(itime('tran "/VDDR/PLUS")) (unticked)
Run mode: Single Run, Sweeps and Corners
Setup values for test LowPower_28_Rail2Railcomparator_SR_speed_TB_1: Vcommon = {From/To}LinearStepCount:0:100:1{From/To}
