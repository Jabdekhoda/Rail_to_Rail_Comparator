ADE simulation setup
Test LowPower_28_R2Rcomparator_offset_TB_V0_1: LowPower_28/R2Rcomparator_offset_TB_V0/schematic, simulator spectre
  Models: /usr/eelocal/tsmchome_eeweiz/Cadence/ViewCadence_RF/models/spectre/crn28ull_1d8_elk_v1d8_2p2_shrink0d9_embedded_usage.scs[GlobalMC_LocalMC_MOS_MOSCAP]
  Variables: tr = 1p; VDD = 0.6; fclk = 1M; resolution = 300u; vin = 23m; delay = 100n; trise = 1p; VCM = 270m; numberoflevels = int(2*vin/resolution); period = numberoflevels/(fclk); TSTOP = delay+2*(numberoflevels/fclk); ramprate = (2*vin/period)
  Temperature: 27.0
  Analysis tran: stop=VAR("TSTOP") errpreset=moderate
  Output v /In0; tran (V) = vtime('tran "/In0")
  Output Offsetf_N = value(vtime('tran "/In0") cross(clip((vtime('tran "/OUT_N") - vtime('tran "/OUTB_N")) (2 / VAR("fclk")) VAR("TSTOP")) "0" 1 "rising" nil nil nil))
  Output Offsetr_N = value(vtime('tran "/In0") cross(clip((vtime('tran "/OUT_N") - vtime('tran "/OUTB_N")) (2 / VAR("fclk")) VAR("TSTOP")) "0" 1 "falling" nil nil nil))
  Output Offsetf_P = value(vtime('tran "/In0") cross(clip((vtime('tran "/OUT_P") - vtime('tran "/OUTB_P")) (2 / VAR("fclk")) VAR("TSTOP")) "0" 1 "rising" nil nil nil))
  Output Offsetr_P = value(vtime('tran "/In0") cross(clip((vtime('tran "/OUT_P") - vtime('tran "/OUTB_P")) (2 / VAR("fclk")) VAR("TSTOP")) "0" 1 "falling" nil nil nil))
  Output Offsetf_R = value(vtime('tran "/In0") cross(clip((vtime('tran "/OUT_R") - vtime('tran "/OUTB_R")) (2 / VAR("fclk")) VAR("TSTOP")) "0" 1 "rising" nil nil nil))
  Output Offsetr_R = value(vtime('tran "/In0") cross(clip((vtime('tran "/OUT_R") - vtime('tran "/OUTB_R")) (2 / VAR("fclk")) VAR("TSTOP")) "0" 1 "falling" nil nil nil))
  Output Offset_N = ((Offsetf_N + Offsetr_N) / 2)
  Output Offset_P = ((Offsetf_P + Offsetr_P) / 2)
  Output Offset_R = ((Offsetf_R + Offsetr_R) / 2)
Run mode: Monte Carlo Sampling
Corners (nominal off):
  model folders: /usr/eelocal/tsmchome_eeweiz/Cadence/ViewCadence_RF/models/spectre
  MC: crn28ull_1d8_elk_v1d8_2p2_shrink0d9_embedded_usage.scs[GlobalMC_LocalMC_MOS_MOSCAP]
Monte Carlo Sampling options: mcnumpoints=100, pointsPerJobPolicy=Group automatically, yeyistostart=3.0, reliabilitymode=singlestress, maxPointsPerJob=10, mcSigmaTarget=3, sssnumpoints=7000, yeexpectedyield=3, mcmethod=all, wcdinitialpoints=200, yeiterations=10, yeusehistorymc=0, yeuseautomcsamples=1, yecreatecorners=0, parasiticanalysis=0, mcFilterPluginEnabled=0, haveyeyieldtostart=1, yeusevarreduction=1
