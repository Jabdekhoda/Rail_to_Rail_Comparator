ADE simulation setup
Run mode: Monte Carlo Sampling
Tests:
  LowPower_28_R2Rcomparator_offset_TB_V0_1: LowPower_28/R2Rcomparator_offset_TB_V0/schematic, simulator spectre
    Variables: tr = 1p; VDD = 0.6; fclk = 1M; resolution = 300u; vin = 23m; delay = 100n; trise = 1p; VCM = 270m; numberoflevels = int(2*vin/resolution); period = numberoflevels/(fclk); TSTOP = delay+2*(numberoflevels/fclk); ramprate = (2*vin/period)
Corners (nominal off):
  model folders: /usr/eelocal/tsmchome_eeweiz/Cadence/ViewCadence_RF/models/spectre
  MC: crn28ull_1d8_elk_v1d8_2p2_shrink0d9_embedded_usage.scs[GlobalMC_LocalMC_MOS_MOSCAP]
Monte Carlo Sampling options: mcnumpoints=100, pointsPerJobPolicy=Group automatically, yeyistostart=3.0, reliabilitymode=singlestress, maxPointsPerJob=10, mcSigmaTarget=3, sssnumpoints=7000, yeexpectedyield=3, mcmethod=all, wcdinitialpoints=200, yeiterations=10, yeusehistorymc=0, yeuseautomcsamples=1, yecreatecorners=0, parasiticanalysis=0, mcFilterPluginEnabled=0, haveyeyieldtostart=1, yeusevarreduction=1
