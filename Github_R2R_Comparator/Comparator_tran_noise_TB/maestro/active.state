ADE simulation setup
Test LowPower_28_Comp_stndrd_tran_noise_TB_V0_1: LowPower_28/Comp_stndrd_tran_noise_TB_V0/schematic, simulator spectre
  Models: /afs/ee.ust.hk/amd64_linux26/usr/eelocal/tsmchome_eeweiz/Cadence/ViewCadence_RF/tsmcN28/../models/spectre/toplevel.scs[TOP_TT]
  Variables: CNOISE_Test = 100f; tr = 0.1p; VDD = 1; vin = 0; fclk = 3G; TSTOP = 0.3u; Vcommon = VDD/2
  Temperature: 27
  Analysis tran: stop=VAR("TSTOP") errpreset=conservative noisefmax=50G
  Output OUT_N = average(clip(vtime('tran "/out_n") 1e-07 VAR("TSTOP")))
  Output OUT_P = average(clip(vtime('tran "/out_p") 1e-07 VAR("TSTOP")))
  Output OUT_R = average(clip(vtime('tran "/out_r") 1e-07 VAR("TSTOP")))
Run mode: Single Run, Sweeps and Corners
Setup values for test LowPower_28_Comp_stndrd_tran_noise_TB_V0_1: vin = {Inclusion List}0{Inclusion List}{From/To}LinearStepCount:-2m:10:2m{From/To}
