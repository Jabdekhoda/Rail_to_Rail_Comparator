ADE simulation setup
Run mode: Single Run, Sweeps and Corners
Tests:
  LowPower_28_Comp_stndrd_tran_noise_TB_V0_1: LowPower_28/Comp_stndrd_tran_noise_TB_V0/schematic, simulator spectre
    Variables: CNOISE_Test = 100f; tr = 0.1p; VDD = 1; vin = {Inclusion List}0{Inclusion List}{From/To}LinearStepCount:-2m:10:2m{From/To}; fclk = 3G; TSTOP = 0.3u; Vcommon = VDD/2
